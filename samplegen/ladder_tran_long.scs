simulator lang=spectre
global 0
V1 (in 0) vsource type=sine ampl=1 freq=1M mag=1
R1 (in n1) resistor r=1k
C1 (n1 0) capacitor c=1p
R2 (n1 n2) resistor r=1k
C2 (n2 0) capacitor c=1p
R3 (n2 n3) resistor r=1k
C3 (n3 0) capacitor c=1p
R4 (n3 n4) resistor r=1k
C4 (n4 0) capacitor c=1p
R5 (n4 n5) resistor r=1k
C5 (n5 0) capacitor c=1p
R6 (n5 n6) resistor r=1k
C6 (n6 0) capacitor c=1p
R7 (n6 n7) resistor r=1k
C7 (n7 0) capacitor c=1p
R8 (n7 n8) resistor r=1k
C8 (n8 0) capacitor c=1p
R9 (n8 n9) resistor r=1k
C9 (n9 0) capacitor c=1p
R10 (n9 n10) resistor r=1k
C10 (n10 0) capacitor c=1p
R11 (n10 n11) resistor r=1k
C11 (n11 0) capacitor c=1p
R12 (n11 n12) resistor r=1k
C12 (n12 0) capacitor c=1p
R13 (n12 n13) resistor r=1k
C13 (n13 0) capacitor c=1p
R14 (n13 n14) resistor r=1k
C14 (n14 0) capacitor c=1p
R15 (n14 n15) resistor r=1k
C15 (n15 0) capacitor c=1p
R16 (n15 n16) resistor r=1k
C16 (n16 0) capacitor c=1p
R17 (n16 n17) resistor r=1k
C17 (n17 0) capacitor c=1p
R18 (n17 n18) resistor r=1k
C18 (n18 0) capacitor c=1p
R19 (n18 n19) resistor r=1k
C19 (n19 0) capacitor c=1p
R20 (n19 n20) resistor r=1k
C20 (n20 0) capacitor c=1p
R21 (n20 n21) resistor r=1k
C21 (n21 0) capacitor c=1p
R22 (n21 n22) resistor r=1k
C22 (n22 0) capacitor c=1p
R23 (n22 n23) resistor r=1k
C23 (n23 0) capacitor c=1p
R24 (n23 n24) resistor r=1k
C24 (n24 0) capacitor c=1p
R25 (n24 n25) resistor r=1k
C25 (n25 0) capacitor c=1p
R26 (n25 n26) resistor r=1k
C26 (n26 0) capacitor c=1p
R27 (n26 n27) resistor r=1k
C27 (n27 0) capacitor c=1p
R28 (n27 n28) resistor r=1k
C28 (n28 0) capacitor c=1p
R29 (n28 n29) resistor r=1k
C29 (n29 0) capacitor c=1p
R30 (n29 n30) resistor r=1k
C30 (n30 0) capacitor c=1p
R31 (n30 n31) resistor r=1k
C31 (n31 0) capacitor c=1p
R32 (n31 n32) resistor r=1k
C32 (n32 0) capacitor c=1p
R33 (n32 n33) resistor r=1k
C33 (n33 0) capacitor c=1p
R34 (n33 n34) resistor r=1k
C34 (n34 0) capacitor c=1p
R35 (n34 n35) resistor r=1k
C35 (n35 0) capacitor c=1p
R36 (n35 n36) resistor r=1k
C36 (n36 0) capacitor c=1p
R37 (n36 n37) resistor r=1k
C37 (n37 0) capacitor c=1p
R38 (n37 n38) resistor r=1k
C38 (n38 0) capacitor c=1p
R39 (n38 n39) resistor r=1k
C39 (n39 0) capacitor c=1p
R40 (n39 n40) resistor r=1k
C40 (n40 0) capacitor c=1p
R41 (n40 n41) resistor r=1k
C41 (n41 0) capacitor c=1p
R42 (n41 n42) resistor r=1k
C42 (n42 0) capacitor c=1p
R43 (n42 n43) resistor r=1k
C43 (n43 0) capacitor c=1p
R44 (n43 n44) resistor r=1k
C44 (n44 0) capacitor c=1p
R45 (n44 n45) resistor r=1k
C45 (n45 0) capacitor c=1p
R46 (n45 n46) resistor r=1k
C46 (n46 0) capacitor c=1p
R47 (n46 n47) resistor r=1k
C47 (n47 0) capacitor c=1p
R48 (n47 n48) resistor r=1k
C48 (n48 0) capacitor c=1p
R49 (n48 n49) resistor r=1k
C49 (n49 0) capacitor c=1p
R50 (n49 n50) resistor r=1k
C50 (n50 0) capacitor c=1p
R51 (n50 n51) resistor r=1k
C51 (n51 0) capacitor c=1p
R52 (n51 n52) resistor r=1k
C52 (n52 0) capacitor c=1p
R53 (n52 n53) resistor r=1k
C53 (n53 0) capacitor c=1p
R54 (n53 n54) resistor r=1k
C54 (n54 0) capacitor c=1p
R55 (n54 n55) resistor r=1k
C55 (n55 0) capacitor c=1p
R56 (n55 n56) resistor r=1k
C56 (n56 0) capacitor c=1p
R57 (n56 n57) resistor r=1k
C57 (n57 0) capacitor c=1p
R58 (n57 n58) resistor r=1k
C58 (n58 0) capacitor c=1p
R59 (n58 n59) resistor r=1k
C59 (n59 0) capacitor c=1p
R60 (n59 n60) resistor r=1k
C60 (n60 0) capacitor c=1p
R61 (n60 n61) resistor r=1k
C61 (n61 0) capacitor c=1p
R62 (n61 n62) resistor r=1k
C62 (n62 0) capacitor c=1p
R63 (n62 n63) resistor r=1k
C63 (n63 0) capacitor c=1p
R64 (n63 n64) resistor r=1k
C64 (n64 0) capacitor c=1p
R65 (n64 n65) resistor r=1k
C65 (n65 0) capacitor c=1p
R66 (n65 n66) resistor r=1k
C66 (n66 0) capacitor c=1p
R67 (n66 n67) resistor r=1k
C67 (n67 0) capacitor c=1p
R68 (n67 n68) resistor r=1k
C68 (n68 0) capacitor c=1p
R69 (n68 n69) resistor r=1k
C69 (n69 0) capacitor c=1p
R70 (n69 n70) resistor r=1k
C70 (n70 0) capacitor c=1p
R71 (n70 n71) resistor r=1k
C71 (n71 0) capacitor c=1p
R72 (n71 n72) resistor r=1k
C72 (n72 0) capacitor c=1p
R73 (n72 n73) resistor r=1k
C73 (n73 0) capacitor c=1p
R74 (n73 n74) resistor r=1k
C74 (n74 0) capacitor c=1p
R75 (n74 n75) resistor r=1k
C75 (n75 0) capacitor c=1p
R76 (n75 n76) resistor r=1k
C76 (n76 0) capacitor c=1p
R77 (n76 n77) resistor r=1k
C77 (n77 0) capacitor c=1p
R78 (n77 n78) resistor r=1k
C78 (n78 0) capacitor c=1p
R79 (n78 n79) resistor r=1k
C79 (n79 0) capacitor c=1p
R80 (n79 n80) resistor r=1k
C80 (n80 0) capacitor c=1p
R81 (n80 n81) resistor r=1k
C81 (n81 0) capacitor c=1p
R82 (n81 n82) resistor r=1k
C82 (n82 0) capacitor c=1p
R83 (n82 n83) resistor r=1k
C83 (n83 0) capacitor c=1p
R84 (n83 n84) resistor r=1k
C84 (n84 0) capacitor c=1p
R85 (n84 n85) resistor r=1k
C85 (n85 0) capacitor c=1p
R86 (n85 n86) resistor r=1k
C86 (n86 0) capacitor c=1p
R87 (n86 n87) resistor r=1k
C87 (n87 0) capacitor c=1p
R88 (n87 n88) resistor r=1k
C88 (n88 0) capacitor c=1p
R89 (n88 n89) resistor r=1k
C89 (n89 0) capacitor c=1p
R90 (n89 n90) resistor r=1k
C90 (n90 0) capacitor c=1p
R91 (n90 n91) resistor r=1k
C91 (n91 0) capacitor c=1p
R92 (n91 n92) resistor r=1k
C92 (n92 0) capacitor c=1p
R93 (n92 n93) resistor r=1k
C93 (n93 0) capacitor c=1p
R94 (n93 n94) resistor r=1k
C94 (n94 0) capacitor c=1p
R95 (n94 n95) resistor r=1k
C95 (n95 0) capacitor c=1p
R96 (n95 n96) resistor r=1k
C96 (n96 0) capacitor c=1p
R97 (n96 n97) resistor r=1k
C97 (n97 0) capacitor c=1p
R98 (n97 n98) resistor r=1k
C98 (n98 0) capacitor c=1p
R99 (n98 n99) resistor r=1k
C99 (n99 0) capacitor c=1p
R100 (n99 n100) resistor r=1k
C100 (n100 0) capacitor c=1p
// ~1M points x 100 nodes; many PSFXL flushes
tran1 tran stop=1m maxstep=1n

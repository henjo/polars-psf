simulator lang=spectre
global 0
V1 (in 0) vsource type=sine ampl=1 freq=1M mag=1
R1 (in n1) resistor r=1k
C1 (n1 0) capacitor c=1p
R2 (n1 n2) resistor r=1k
C2 (n2 0) capacitor c=1p
R3 (n2 n3) resistor r=1k
C3 (n3 0) capacitor c=1p
R4 (n3 n4) resistor r=1k
C4 (n4 0) capacitor c=1p
R5 (n4 n5) resistor r=1k
C5 (n5 0) capacitor c=1p
R6 (n5 n6) resistor r=1k
C6 (n6 0) capacitor c=1p
R7 (n6 n7) resistor r=1k
C7 (n7 0) capacitor c=1p
R8 (n7 n8) resistor r=1k
C8 (n8 0) capacitor c=1p
R9 (n8 n9) resistor r=1k
C9 (n9 0) capacitor c=1p
R10 (n9 n10) resistor r=1k
C10 (n10 0) capacitor c=1p
R11 (n10 n11) resistor r=1k
C11 (n11 0) capacitor c=1p
R12 (n11 n12) resistor r=1k
C12 (n12 0) capacitor c=1p
R13 (n12 n13) resistor r=1k
C13 (n13 0) capacitor c=1p
R14 (n13 n14) resistor r=1k
C14 (n14 0) capacitor c=1p
R15 (n14 n15) resistor r=1k
C15 (n15 0) capacitor c=1p
R16 (n15 n16) resistor r=1k
C16 (n16 0) capacitor c=1p
R17 (n16 n17) resistor r=1k
C17 (n17 0) capacitor c=1p
R18 (n17 n18) resistor r=1k
C18 (n18 0) capacitor c=1p
R19 (n18 n19) resistor r=1k
C19 (n19 0) capacitor c=1p
R20 (n19 n20) resistor r=1k
C20 (n20 0) capacitor c=1p
R21 (n20 n21) resistor r=1k
C21 (n21 0) capacitor c=1p
R22 (n21 n22) resistor r=1k
C22 (n22 0) capacitor c=1p
R23 (n22 n23) resistor r=1k
C23 (n23 0) capacitor c=1p
R24 (n23 n24) resistor r=1k
C24 (n24 0) capacitor c=1p
R25 (n24 n25) resistor r=1k
C25 (n25 0) capacitor c=1p
R26 (n25 n26) resistor r=1k
C26 (n26 0) capacitor c=1p
R27 (n26 n27) resistor r=1k
C27 (n27 0) capacitor c=1p
R28 (n27 n28) resistor r=1k
C28 (n28 0) capacitor c=1p
R29 (n28 n29) resistor r=1k
C29 (n29 0) capacitor c=1p
R30 (n29 n30) resistor r=1k
C30 (n30 0) capacitor c=1p
R31 (n30 n31) resistor r=1k
C31 (n31 0) capacitor c=1p
R32 (n31 n32) resistor r=1k
C32 (n32 0) capacitor c=1p
R33 (n32 n33) resistor r=1k
C33 (n33 0) capacitor c=1p
R34 (n33 n34) resistor r=1k
C34 (n34 0) capacitor c=1p
R35 (n34 n35) resistor r=1k
C35 (n35 0) capacitor c=1p
R36 (n35 n36) resistor r=1k
C36 (n36 0) capacitor c=1p
R37 (n36 n37) resistor r=1k
C37 (n37 0) capacitor c=1p
R38 (n37 n38) resistor r=1k
C38 (n38 0) capacitor c=1p
R39 (n38 n39) resistor r=1k
C39 (n39 0) capacitor c=1p
R40 (n39 n40) resistor r=1k
C40 (n40 0) capacitor c=1p
R41 (n40 n41) resistor r=1k
C41 (n41 0) capacitor c=1p
R42 (n41 n42) resistor r=1k
C42 (n42 0) capacitor c=1p
R43 (n42 n43) resistor r=1k
C43 (n43 0) capacitor c=1p
R44 (n43 n44) resistor r=1k
C44 (n44 0) capacitor c=1p
R45 (n44 n45) resistor r=1k
C45 (n45 0) capacitor c=1p
R46 (n45 n46) resistor r=1k
C46 (n46 0) capacitor c=1p
R47 (n46 n47) resistor r=1k
C47 (n47 0) capacitor c=1p
R48 (n47 n48) resistor r=1k
C48 (n48 0) capacitor c=1p
R49 (n48 n49) resistor r=1k
C49 (n49 0) capacitor c=1p
R50 (n49 n50) resistor r=1k
C50 (n50 0) capacitor c=1p
R51 (n50 n51) resistor r=1k
C51 (n51 0) capacitor c=1p
R52 (n51 n52) resistor r=1k
C52 (n52 0) capacitor c=1p
R53 (n52 n53) resistor r=1k
C53 (n53 0) capacitor c=1p
R54 (n53 n54) resistor r=1k
C54 (n54 0) capacitor c=1p
R55 (n54 n55) resistor r=1k
C55 (n55 0) capacitor c=1p
R56 (n55 n56) resistor r=1k
C56 (n56 0) capacitor c=1p
R57 (n56 n57) resistor r=1k
C57 (n57 0) capacitor c=1p
R58 (n57 n58) resistor r=1k
C58 (n58 0) capacitor c=1p
R59 (n58 n59) resistor r=1k
C59 (n59 0) capacitor c=1p
R60 (n59 n60) resistor r=1k
C60 (n60 0) capacitor c=1p
R61 (n60 n61) resistor r=1k
C61 (n61 0) capacitor c=1p
R62 (n61 n62) resistor r=1k
C62 (n62 0) capacitor c=1p
R63 (n62 n63) resistor r=1k
C63 (n63 0) capacitor c=1p
R64 (n63 n64) resistor r=1k
C64 (n64 0) capacitor c=1p
R65 (n64 n65) resistor r=1k
C65 (n65 0) capacitor c=1p
R66 (n65 n66) resistor r=1k
C66 (n66 0) capacitor c=1p
R67 (n66 n67) resistor r=1k
C67 (n67 0) capacitor c=1p
R68 (n67 n68) resistor r=1k
C68 (n68 0) capacitor c=1p
R69 (n68 n69) resistor r=1k
C69 (n69 0) capacitor c=1p
R70 (n69 n70) resistor r=1k
C70 (n70 0) capacitor c=1p
R71 (n70 n71) resistor r=1k
C71 (n71 0) capacitor c=1p
R72 (n71 n72) resistor r=1k
C72 (n72 0) capacitor c=1p
R73 (n72 n73) resistor r=1k
C73 (n73 0) capacitor c=1p
R74 (n73 n74) resistor r=1k
C74 (n74 0) capacitor c=1p
R75 (n74 n75) resistor r=1k
C75 (n75 0) capacitor c=1p
R76 (n75 n76) resistor r=1k
C76 (n76 0) capacitor c=1p
R77 (n76 n77) resistor r=1k
C77 (n77 0) capacitor c=1p
R78 (n77 n78) resistor r=1k
C78 (n78 0) capacitor c=1p
R79 (n78 n79) resistor r=1k
C79 (n79 0) capacitor c=1p
R80 (n79 n80) resistor r=1k
C80 (n80 0) capacitor c=1p
R81 (n80 n81) resistor r=1k
C81 (n81 0) capacitor c=1p
R82 (n81 n82) resistor r=1k
C82 (n82 0) capacitor c=1p
R83 (n82 n83) resistor r=1k
C83 (n83 0) capacitor c=1p
R84 (n83 n84) resistor r=1k
C84 (n84 0) capacitor c=1p
R85 (n84 n85) resistor r=1k
C85 (n85 0) capacitor c=1p
R86 (n85 n86) resistor r=1k
C86 (n86 0) capacitor c=1p
R87 (n86 n87) resistor r=1k
C87 (n87 0) capacitor c=1p
R88 (n87 n88) resistor r=1k
C88 (n88 0) capacitor c=1p
R89 (n88 n89) resistor r=1k
C89 (n89 0) capacitor c=1p
R90 (n89 n90) resistor r=1k
C90 (n90 0) capacitor c=1p
R91 (n90 n91) resistor r=1k
C91 (n91 0) capacitor c=1p
R92 (n91 n92) resistor r=1k
C92 (n92 0) capacitor c=1p
R93 (n92 n93) resistor r=1k
C93 (n93 0) capacitor c=1p
R94 (n93 n94) resistor r=1k
C94 (n94 0) capacitor c=1p
R95 (n94 n95) resistor r=1k
C95 (n95 0) capacitor c=1p
R96 (n95 n96) resistor r=1k
C96 (n96 0) capacitor c=1p
R97 (n96 n97) resistor r=1k
C97 (n97 0) capacitor c=1p
R98 (n97 n98) resistor r=1k
C98 (n98 0) capacitor c=1p
R99 (n98 n99) resistor r=1k
C99 (n99 0) capacitor c=1p
R100 (n99 n100) resistor r=1k
C100 (n100 0) capacitor c=1p
R101 (n100 n101) resistor r=1k
C101 (n101 0) capacitor c=1p
R102 (n101 n102) resistor r=1k
C102 (n102 0) capacitor c=1p
R103 (n102 n103) resistor r=1k
C103 (n103 0) capacitor c=1p
R104 (n103 n104) resistor r=1k
C104 (n104 0) capacitor c=1p
R105 (n104 n105) resistor r=1k
C105 (n105 0) capacitor c=1p
R106 (n105 n106) resistor r=1k
C106 (n106 0) capacitor c=1p
R107 (n106 n107) resistor r=1k
C107 (n107 0) capacitor c=1p
R108 (n107 n108) resistor r=1k
C108 (n108 0) capacitor c=1p
R109 (n108 n109) resistor r=1k
C109 (n109 0) capacitor c=1p
R110 (n109 n110) resistor r=1k
C110 (n110 0) capacitor c=1p
R111 (n110 n111) resistor r=1k
C111 (n111 0) capacitor c=1p
R112 (n111 n112) resistor r=1k
C112 (n112 0) capacitor c=1p
R113 (n112 n113) resistor r=1k
C113 (n113 0) capacitor c=1p
R114 (n113 n114) resistor r=1k
C114 (n114 0) capacitor c=1p
R115 (n114 n115) resistor r=1k
C115 (n115 0) capacitor c=1p
R116 (n115 n116) resistor r=1k
C116 (n116 0) capacitor c=1p
R117 (n116 n117) resistor r=1k
C117 (n117 0) capacitor c=1p
R118 (n117 n118) resistor r=1k
C118 (n118 0) capacitor c=1p
R119 (n118 n119) resistor r=1k
C119 (n119 0) capacitor c=1p
R120 (n119 n120) resistor r=1k
C120 (n120 0) capacitor c=1p
R121 (n120 n121) resistor r=1k
C121 (n121 0) capacitor c=1p
R122 (n121 n122) resistor r=1k
C122 (n122 0) capacitor c=1p
R123 (n122 n123) resistor r=1k
C123 (n123 0) capacitor c=1p
R124 (n123 n124) resistor r=1k
C124 (n124 0) capacitor c=1p
R125 (n124 n125) resistor r=1k
C125 (n125 0) capacitor c=1p
R126 (n125 n126) resistor r=1k
C126 (n126 0) capacitor c=1p
R127 (n126 n127) resistor r=1k
C127 (n127 0) capacitor c=1p
R128 (n127 n128) resistor r=1k
C128 (n128 0) capacitor c=1p
R129 (n128 n129) resistor r=1k
C129 (n129 0) capacitor c=1p
R130 (n129 n130) resistor r=1k
C130 (n130 0) capacitor c=1p
R131 (n130 n131) resistor r=1k
C131 (n131 0) capacitor c=1p
R132 (n131 n132) resistor r=1k
C132 (n132 0) capacitor c=1p
R133 (n132 n133) resistor r=1k
C133 (n133 0) capacitor c=1p
R134 (n133 n134) resistor r=1k
C134 (n134 0) capacitor c=1p
R135 (n134 n135) resistor r=1k
C135 (n135 0) capacitor c=1p
R136 (n135 n136) resistor r=1k
C136 (n136 0) capacitor c=1p
R137 (n136 n137) resistor r=1k
C137 (n137 0) capacitor c=1p
R138 (n137 n138) resistor r=1k
C138 (n138 0) capacitor c=1p
R139 (n138 n139) resistor r=1k
C139 (n139 0) capacitor c=1p
R140 (n139 n140) resistor r=1k
C140 (n140 0) capacitor c=1p
R141 (n140 n141) resistor r=1k
C141 (n141 0) capacitor c=1p
R142 (n141 n142) resistor r=1k
C142 (n142 0) capacitor c=1p
R143 (n142 n143) resistor r=1k
C143 (n143 0) capacitor c=1p
R144 (n143 n144) resistor r=1k
C144 (n144 0) capacitor c=1p
R145 (n144 n145) resistor r=1k
C145 (n145 0) capacitor c=1p
R146 (n145 n146) resistor r=1k
C146 (n146 0) capacitor c=1p
R147 (n146 n147) resistor r=1k
C147 (n147 0) capacitor c=1p
R148 (n147 n148) resistor r=1k
C148 (n148 0) capacitor c=1p
R149 (n148 n149) resistor r=1k
C149 (n149 0) capacitor c=1p
R150 (n149 n150) resistor r=1k
C150 (n150 0) capacitor c=1p
R151 (n150 n151) resistor r=1k
C151 (n151 0) capacitor c=1p
R152 (n151 n152) resistor r=1k
C152 (n152 0) capacitor c=1p
R153 (n152 n153) resistor r=1k
C153 (n153 0) capacitor c=1p
R154 (n153 n154) resistor r=1k
C154 (n154 0) capacitor c=1p
R155 (n154 n155) resistor r=1k
C155 (n155 0) capacitor c=1p
R156 (n155 n156) resistor r=1k
C156 (n156 0) capacitor c=1p
R157 (n156 n157) resistor r=1k
C157 (n157 0) capacitor c=1p
R158 (n157 n158) resistor r=1k
C158 (n158 0) capacitor c=1p
R159 (n158 n159) resistor r=1k
C159 (n159 0) capacitor c=1p
R160 (n159 n160) resistor r=1k
C160 (n160 0) capacitor c=1p
R161 (n160 n161) resistor r=1k
C161 (n161 0) capacitor c=1p
R162 (n161 n162) resistor r=1k
C162 (n162 0) capacitor c=1p
R163 (n162 n163) resistor r=1k
C163 (n163 0) capacitor c=1p
R164 (n163 n164) resistor r=1k
C164 (n164 0) capacitor c=1p
R165 (n164 n165) resistor r=1k
C165 (n165 0) capacitor c=1p
R166 (n165 n166) resistor r=1k
C166 (n166 0) capacitor c=1p
R167 (n166 n167) resistor r=1k
C167 (n167 0) capacitor c=1p
R168 (n167 n168) resistor r=1k
C168 (n168 0) capacitor c=1p
R169 (n168 n169) resistor r=1k
C169 (n169 0) capacitor c=1p
R170 (n169 n170) resistor r=1k
C170 (n170 0) capacitor c=1p
R171 (n170 n171) resistor r=1k
C171 (n171 0) capacitor c=1p
R172 (n171 n172) resistor r=1k
C172 (n172 0) capacitor c=1p
R173 (n172 n173) resistor r=1k
C173 (n173 0) capacitor c=1p
R174 (n173 n174) resistor r=1k
C174 (n174 0) capacitor c=1p
R175 (n174 n175) resistor r=1k
C175 (n175 0) capacitor c=1p
R176 (n175 n176) resistor r=1k
C176 (n176 0) capacitor c=1p
R177 (n176 n177) resistor r=1k
C177 (n177 0) capacitor c=1p
R178 (n177 n178) resistor r=1k
C178 (n178 0) capacitor c=1p
R179 (n178 n179) resistor r=1k
C179 (n179 0) capacitor c=1p
R180 (n179 n180) resistor r=1k
C180 (n180 0) capacitor c=1p
R181 (n180 n181) resistor r=1k
C181 (n181 0) capacitor c=1p
R182 (n181 n182) resistor r=1k
C182 (n182 0) capacitor c=1p
R183 (n182 n183) resistor r=1k
C183 (n183 0) capacitor c=1p
R184 (n183 n184) resistor r=1k
C184 (n184 0) capacitor c=1p
R185 (n184 n185) resistor r=1k
C185 (n185 0) capacitor c=1p
R186 (n185 n186) resistor r=1k
C186 (n186 0) capacitor c=1p
R187 (n186 n187) resistor r=1k
C187 (n187 0) capacitor c=1p
R188 (n187 n188) resistor r=1k
C188 (n188 0) capacitor c=1p
R189 (n188 n189) resistor r=1k
C189 (n189 0) capacitor c=1p
R190 (n189 n190) resistor r=1k
C190 (n190 0) capacitor c=1p
R191 (n190 n191) resistor r=1k
C191 (n191 0) capacitor c=1p
R192 (n191 n192) resistor r=1k
C192 (n192 0) capacitor c=1p
R193 (n192 n193) resistor r=1k
C193 (n193 0) capacitor c=1p
R194 (n193 n194) resistor r=1k
C194 (n194 0) capacitor c=1p
R195 (n194 n195) resistor r=1k
C195 (n195 0) capacitor c=1p
R196 (n195 n196) resistor r=1k
C196 (n196 0) capacitor c=1p
R197 (n196 n197) resistor r=1k
C197 (n197 0) capacitor c=1p
R198 (n197 n198) resistor r=1k
C198 (n198 0) capacitor c=1p
R199 (n198 n199) resistor r=1k
C199 (n199 0) capacitor c=1p
R200 (n199 n200) resistor r=1k
C200 (n200 0) capacitor c=1p
R201 (n200 n201) resistor r=1k
C201 (n201 0) capacitor c=1p
R202 (n201 n202) resistor r=1k
C202 (n202 0) capacitor c=1p
R203 (n202 n203) resistor r=1k
C203 (n203 0) capacitor c=1p
R204 (n203 n204) resistor r=1k
C204 (n204 0) capacitor c=1p
R205 (n204 n205) resistor r=1k
C205 (n205 0) capacitor c=1p
R206 (n205 n206) resistor r=1k
C206 (n206 0) capacitor c=1p
R207 (n206 n207) resistor r=1k
C207 (n207 0) capacitor c=1p
R208 (n207 n208) resistor r=1k
C208 (n208 0) capacitor c=1p
R209 (n208 n209) resistor r=1k
C209 (n209 0) capacitor c=1p
R210 (n209 n210) resistor r=1k
C210 (n210 0) capacitor c=1p
R211 (n210 n211) resistor r=1k
C211 (n211 0) capacitor c=1p
R212 (n211 n212) resistor r=1k
C212 (n212 0) capacitor c=1p
R213 (n212 n213) resistor r=1k
C213 (n213 0) capacitor c=1p
R214 (n213 n214) resistor r=1k
C214 (n214 0) capacitor c=1p
R215 (n214 n215) resistor r=1k
C215 (n215 0) capacitor c=1p
R216 (n215 n216) resistor r=1k
C216 (n216 0) capacitor c=1p
R217 (n216 n217) resistor r=1k
C217 (n217 0) capacitor c=1p
R218 (n217 n218) resistor r=1k
C218 (n218 0) capacitor c=1p
R219 (n218 n219) resistor r=1k
C219 (n219 0) capacitor c=1p
R220 (n219 n220) resistor r=1k
C220 (n220 0) capacitor c=1p
R221 (n220 n221) resistor r=1k
C221 (n221 0) capacitor c=1p
R222 (n221 n222) resistor r=1k
C222 (n222 0) capacitor c=1p
R223 (n222 n223) resistor r=1k
C223 (n223 0) capacitor c=1p
R224 (n223 n224) resistor r=1k
C224 (n224 0) capacitor c=1p
R225 (n224 n225) resistor r=1k
C225 (n225 0) capacitor c=1p
R226 (n225 n226) resistor r=1k
C226 (n226 0) capacitor c=1p
R227 (n226 n227) resistor r=1k
C227 (n227 0) capacitor c=1p
R228 (n227 n228) resistor r=1k
C228 (n228 0) capacitor c=1p
R229 (n228 n229) resistor r=1k
C229 (n229 0) capacitor c=1p
R230 (n229 n230) resistor r=1k
C230 (n230 0) capacitor c=1p
R231 (n230 n231) resistor r=1k
C231 (n231 0) capacitor c=1p
R232 (n231 n232) resistor r=1k
C232 (n232 0) capacitor c=1p
R233 (n232 n233) resistor r=1k
C233 (n233 0) capacitor c=1p
R234 (n233 n234) resistor r=1k
C234 (n234 0) capacitor c=1p
R235 (n234 n235) resistor r=1k
C235 (n235 0) capacitor c=1p
R236 (n235 n236) resistor r=1k
C236 (n236 0) capacitor c=1p
R237 (n236 n237) resistor r=1k
C237 (n237 0) capacitor c=1p
R238 (n237 n238) resistor r=1k
C238 (n238 0) capacitor c=1p
R239 (n238 n239) resistor r=1k
C239 (n239 0) capacitor c=1p
R240 (n239 n240) resistor r=1k
C240 (n240 0) capacitor c=1p
R241 (n240 n241) resistor r=1k
C241 (n241 0) capacitor c=1p
R242 (n241 n242) resistor r=1k
C242 (n242 0) capacitor c=1p
R243 (n242 n243) resistor r=1k
C243 (n243 0) capacitor c=1p
R244 (n243 n244) resistor r=1k
C244 (n244 0) capacitor c=1p
R245 (n244 n245) resistor r=1k
C245 (n245 0) capacitor c=1p
R246 (n245 n246) resistor r=1k
C246 (n246 0) capacitor c=1p
R247 (n246 n247) resistor r=1k
C247 (n247 0) capacitor c=1p
R248 (n247 n248) resistor r=1k
C248 (n248 0) capacitor c=1p
R249 (n248 n249) resistor r=1k
C249 (n249 0) capacitor c=1p
R250 (n249 n250) resistor r=1k
C250 (n250 0) capacitor c=1p
R251 (n250 n251) resistor r=1k
C251 (n251 0) capacitor c=1p
R252 (n251 n252) resistor r=1k
C252 (n252 0) capacitor c=1p
R253 (n252 n253) resistor r=1k
C253 (n253 0) capacitor c=1p
R254 (n253 n254) resistor r=1k
C254 (n254 0) capacitor c=1p
R255 (n254 n255) resistor r=1k
C255 (n255 0) capacitor c=1p
R256 (n255 n256) resistor r=1k
C256 (n256 0) capacitor c=1p
R257 (n256 n257) resistor r=1k
C257 (n257 0) capacitor c=1p
R258 (n257 n258) resistor r=1k
C258 (n258 0) capacitor c=1p
R259 (n258 n259) resistor r=1k
C259 (n259 0) capacitor c=1p
R260 (n259 n260) resistor r=1k
C260 (n260 0) capacitor c=1p
R261 (n260 n261) resistor r=1k
C261 (n261 0) capacitor c=1p
R262 (n261 n262) resistor r=1k
C262 (n262 0) capacitor c=1p
R263 (n262 n263) resistor r=1k
C263 (n263 0) capacitor c=1p
R264 (n263 n264) resistor r=1k
C264 (n264 0) capacitor c=1p
R265 (n264 n265) resistor r=1k
C265 (n265 0) capacitor c=1p
R266 (n265 n266) resistor r=1k
C266 (n266 0) capacitor c=1p
R267 (n266 n267) resistor r=1k
C267 (n267 0) capacitor c=1p
R268 (n267 n268) resistor r=1k
C268 (n268 0) capacitor c=1p
R269 (n268 n269) resistor r=1k
C269 (n269 0) capacitor c=1p
R270 (n269 n270) resistor r=1k
C270 (n270 0) capacitor c=1p
R271 (n270 n271) resistor r=1k
C271 (n271 0) capacitor c=1p
R272 (n271 n272) resistor r=1k
C272 (n272 0) capacitor c=1p
R273 (n272 n273) resistor r=1k
C273 (n273 0) capacitor c=1p
R274 (n273 n274) resistor r=1k
C274 (n274 0) capacitor c=1p
R275 (n274 n275) resistor r=1k
C275 (n275 0) capacitor c=1p
R276 (n275 n276) resistor r=1k
C276 (n276 0) capacitor c=1p
R277 (n276 n277) resistor r=1k
C277 (n277 0) capacitor c=1p
R278 (n277 n278) resistor r=1k
C278 (n278 0) capacitor c=1p
R279 (n278 n279) resistor r=1k
C279 (n279 0) capacitor c=1p
R280 (n279 n280) resistor r=1k
C280 (n280 0) capacitor c=1p
R281 (n280 n281) resistor r=1k
C281 (n281 0) capacitor c=1p
R282 (n281 n282) resistor r=1k
C282 (n282 0) capacitor c=1p
R283 (n282 n283) resistor r=1k
C283 (n283 0) capacitor c=1p
R284 (n283 n284) resistor r=1k
C284 (n284 0) capacitor c=1p
R285 (n284 n285) resistor r=1k
C285 (n285 0) capacitor c=1p
R286 (n285 n286) resistor r=1k
C286 (n286 0) capacitor c=1p
R287 (n286 n287) resistor r=1k
C287 (n287 0) capacitor c=1p
R288 (n287 n288) resistor r=1k
C288 (n288 0) capacitor c=1p
R289 (n288 n289) resistor r=1k
C289 (n289 0) capacitor c=1p
R290 (n289 n290) resistor r=1k
C290 (n290 0) capacitor c=1p
R291 (n290 n291) resistor r=1k
C291 (n291 0) capacitor c=1p
R292 (n291 n292) resistor r=1k
C292 (n292 0) capacitor c=1p
R293 (n292 n293) resistor r=1k
C293 (n293 0) capacitor c=1p
R294 (n293 n294) resistor r=1k
C294 (n294 0) capacitor c=1p
R295 (n294 n295) resistor r=1k
C295 (n295 0) capacitor c=1p
R296 (n295 n296) resistor r=1k
C296 (n296 0) capacitor c=1p
R297 (n296 n297) resistor r=1k
C297 (n297 0) capacitor c=1p
R298 (n297 n298) resistor r=1k
C298 (n298 0) capacitor c=1p
R299 (n298 n299) resistor r=1k
C299 (n299 0) capacitor c=1p
R300 (n299 n300) resistor r=1k
C300 (n300 0) capacitor c=1p
// >2 GiB psfbin unless PSF_MAX_FILE_SIZE lowers the split size
tran1 tran stop=1m maxstep=1n
